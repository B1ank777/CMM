* Ideal crossbar read-energy validation
* rows=128 cols=128 pulse_ns=10
* Each row is collapsed to an equivalent conductance because columns are ideal virtual ground.
Vrow0 row0 0 PULSE(0 -0.0333861518317 0 0.001n 0.001n 10n 30n)
Vrow1 row1 0 PULSE(0 -0.00251606280838 0 0.001n 0.001n 10n 30n)
Vrow2 row2 0 PULSE(0 -0.00825923097277 0 0.001n 0.001n 10n 30n)
Vrow3 row3 0 PULSE(0 -0.00822554865566 0 0.001n 0.001n 10n 30n)
Vrow4 row4 0 PULSE(0 -0.00245601667246 0 0.001n 0.001n 10n 30n)
Vrow5 row5 0 PULSE(0 0.00876553851743 0 0.001n 0.001n 10n 30n)
Vrow6 row6 0 PULSE(0 0.0184713038389 0 0.001n 0.001n 10n 30n)
Vrow7 row7 0 PULSE(0 0.0514275363881 0 0.001n 0.001n 10n 30n)
Vrow8 row8 0 PULSE(0 -0.0157731612202 0 0.001n 0.001n 10n 30n)
Vrow9 row9 0 PULSE(0 0.0273949344085 0 0.001n 0.001n 10n 30n)
Vrow10 row10 0 PULSE(0 0.0330990179015 0 0.001n 0.001n 10n 30n)
Vrow11 row11 0 PULSE(0 0.1 0 0.001n 0.001n 10n 30n)
Vrow12 row12 0 PULSE(0 0.0862060029206 0 0.001n 0.001n 10n 30n)
Vrow13 row13 0 PULSE(0 0.05680594697 0 0.001n 0.001n 10n 30n)
Vrow14 row14 0 PULSE(0 0.0200702772292 0 0.001n 0.001n 10n 30n)
Vrow15 row15 0 PULSE(0 0.053543986527 0 0.001n 0.001n 10n 30n)
Vrow16 row16 0 PULSE(0 -0.0705764535696 0 0.001n 0.001n 10n 30n)
Vrow17 row17 0 PULSE(0 -0.0481591322005 0 0.001n 0.001n 10n 30n)
Vrow18 row18 0 PULSE(0 0.0199446999864 0 0.001n 0.001n 10n 30n)
Vrow19 row19 0 PULSE(0 -0.00862059916945 0 0.001n 0.001n 10n 30n)
Vrow20 row20 0 PULSE(0 0.00454908438207 0 0.001n 0.001n 10n 30n)
Vrow21 row21 0 PULSE(0 0.00985632470366 0 0.001n 0.001n 10n 30n)
Vrow22 row22 0 PULSE(0 -0.0767907154847 0 0.001n 0.001n 10n 30n)
Vrow23 row23 0 PULSE(0 -0.0824932104936 0 0.001n 0.001n 10n 30n)
Vrow24 row24 0 PULSE(0 0.0136174648603 0 0.001n 0.001n 10n 30n)
Vrow25 row25 0 PULSE(0 -0.00513309012688 0 0.001n 0.001n 10n 30n)
Vrow26 row26 0 PULSE(0 -0.0608985723177 0 0.001n 0.001n 10n 30n)
Vrow27 row27 0 PULSE(0 -0.0561618868452 0 0.001n 0.001n 10n 30n)
Vrow28 row28 0 PULSE(0 0.0138494115986 0 0.001n 0.001n 10n 30n)
Vrow29 row29 0 PULSE(0 -0.0427536191617 0 0.001n 0.001n 10n 30n)
Vrow30 row30 0 PULSE(0 -0.0129715243744 0 0.001n 0.001n 10n 30n)
Vrow31 row31 0 PULSE(0 -0.0976949019428 0 0.001n 0.001n 10n 30n)
Vrow32 row32 0 PULSE(0 -0.00880745793829 0 0.001n 0.001n 10n 30n)
Vrow33 row33 0 PULSE(0 -0.0623492960827 0 0.001n 0.001n 10n 30n)
Vrow34 row34 0 PULSE(0 0.0382355130253 0 0.001n 0.001n 10n 30n)
Vrow35 row35 0 PULSE(0 -0.0715114139596 0 0.001n 0.001n 10n 30n)
Vrow36 row36 0 PULSE(0 0.0388861628332 0 0.001n 0.001n 10n 30n)
Vrow37 row37 0 PULSE(0 -0.0239836789156 0 0.001n 0.001n 10n 30n)
Vrow38 row38 0 PULSE(0 0.0230465027868 0 0.001n 0.001n 10n 30n)
Vrow39 row39 0 PULSE(0 0.0454913995095 0 0.001n 0.001n 10n 30n)
Vrow40 row40 0 PULSE(0 -0.0103583235555 0 0.001n 0.001n 10n 30n)
Vrow41 row41 0 PULSE(0 0.0306649747908 0 0.001n 0.001n 10n 30n)
Vrow42 row42 0 PULSE(0 -0.0693370487021 0 0.001n 0.001n 10n 30n)
Vrow43 row43 0 PULSE(0 0.00540376949513 0 0.001n 0.001n 10n 30n)
Vrow44 row44 0 PULSE(0 0.0923923737498 0 0.001n 0.001n 10n 30n)
Vrow45 row45 0 PULSE(0 -0.0123449698491 0 0.001n 0.001n 10n 30n)
Vrow46 row46 0 PULSE(0 -0.0202805170241 0 0.001n 0.001n 10n 30n)
Vrow47 row47 0 PULSE(0 -0.0380851599216 0 0.001n 0.001n 10n 30n)
Vrow48 row48 0 PULSE(0 -0.0117130661178 0 0.001n 0.001n 10n 30n)
Vrow49 row49 0 PULSE(0 -0.0370607392524 0 0.001n 0.001n 10n 30n)
Vrow50 row50 0 PULSE(0 0.00611996812592 0 0.001n 0.001n 10n 30n)
Vrow51 row51 0 PULSE(0 0.011440473412 0 0.001n 0.001n 10n 30n)
Vrow52 row52 0 PULSE(0 -0.0458921689869 0 0.001n 0.001n 10n 30n)
Vrow53 row53 0 PULSE(0 0.023706909423 0 0.001n 0.001n 10n 30n)
Vrow54 row54 0 PULSE(0 -0.0208352992928 0 0.001n 0.001n 10n 30n)
Vrow55 row55 0 PULSE(0 -0.0412682350112 0 0.001n 0.001n 10n 30n)
Vrow56 row56 0 PULSE(0 0.036189037574 0 0.001n 0.001n 10n 30n)
Vrow57 row57 0 PULSE(0 -0.0326573267172 0 0.001n 0.001n 10n 30n)
Vrow58 row58 0 PULSE(0 -0.00503808488769 0 0.001n 0.001n 10n 30n)
Vrow59 row59 0 PULSE(0 -0.0259967316519 0 0.001n 0.001n 10n 30n)
Vrow60 row60 0 PULSE(0 -0.00364326818416 0 0.001n 0.001n 10n 30n)
Vrow61 row61 0 PULSE(0 0.0334092297547 0 0.001n 0.001n 10n 30n)
Vrow62 row62 0 PULSE(0 -0.0147631996851 0 0.001n 0.001n 10n 30n)
Vrow63 row63 0 PULSE(0 0.0171495630153 0 0.001n 0.001n 10n 30n)
Vrow64 row64 0 PULSE(0 0.00988184779763 0 0.001n 0.001n 10n 30n)
Vrow65 row65 0 PULSE(0 -0.0274943409554 0 0.001n 0.001n 10n 30n)
Vrow66 row66 0 PULSE(0 -0.0206742618096 0 0.001n 0.001n 10n 30n)
Vrow67 row67 0 PULSE(0 0.0370845552873 0 0.001n 0.001n 10n 30n)
Vrow68 row68 0 PULSE(0 0.0806185411003 0 0.001n 0.001n 10n 30n)
Vrow69 row69 0 PULSE(0 0.0104683751907 0 0.001n 0.001n 10n 30n)
Vrow70 row70 0 PULSE(0 -0.0764870231517 0 0.001n 0.001n 10n 30n)
Vrow71 row71 0 PULSE(0 -0.0141614925868 0 0.001n 0.001n 10n 30n)
Vrow72 row72 0 PULSE(0 0.0643042091797 0 0.001n 0.001n 10n 30n)
Vrow73 row73 0 PULSE(0 -0.0311474782282 0 0.001n 0.001n 10n 30n)
Vrow74 row74 0 PULSE(0 0.0441811639693 0 0.001n 0.001n 10n 30n)
Vrow75 row75 0 PULSE(0 -0.0103508687661 0 0.001n 0.001n 10n 30n)
Vrow76 row76 0 PULSE(0 -0.00681870114991 0 0.001n 0.001n 10n 30n)
Vrow77 row77 0 PULSE(0 0.00929725198431 0 0.001n 0.001n 10n 30n)
Vrow78 row78 0 PULSE(0 -0.0224093494804 0 0.001n 0.001n 10n 30n)
Vrow79 row79 0 PULSE(0 0.0237934340937 0 0.001n 0.001n 10n 30n)
Vrow80 row80 0 PULSE(0 -0.0204196805766 0 0.001n 0.001n 10n 30n)
Vrow81 row81 0 PULSE(0 0.0356786963743 0 0.001n 0.001n 10n 30n)
Vrow82 row82 0 PULSE(0 -0.0218445872658 0 0.001n 0.001n 10n 30n)
Vrow83 row83 0 PULSE(0 -0.00700774548758 0 0.001n 0.001n 10n 30n)
Vrow84 row84 0 PULSE(0 0.0237565397271 0 0.001n 0.001n 10n 30n)
Vrow85 row85 0 PULSE(0 -0.0186403160174 0 0.001n 0.001n 10n 30n)
Vrow86 row86 0 PULSE(0 -0.0258265253039 0 0.001n 0.001n 10n 30n)
Vrow87 row87 0 PULSE(0 0.0217062305846 0 0.001n 0.001n 10n 30n)
Vrow88 row88 0 PULSE(0 -0.046987785175 0 0.001n 0.001n 10n 30n)
Vrow89 row89 0 PULSE(0 -0.0072097278315 0 0.001n 0.001n 10n 30n)
Vrow90 row90 0 PULSE(0 -0.0263345342946 0 0.001n 0.001n 10n 30n)
Vrow91 row91 0 PULSE(0 0.0193393023288 0 0.001n 0.001n 10n 30n)
Vrow92 row92 0 PULSE(0 -0.0336095471372 0 0.001n 0.001n 10n 30n)
Vrow93 row93 0 PULSE(0 0.000873155450061 0 0.001n 0.001n 10n 30n)
Vrow94 row94 0 PULSE(0 0.00722117487986 0 0.001n 0.001n 10n 30n)
Vrow95 row95 0 PULSE(0 -0.0166794615409 0 0.001n 0.001n 10n 30n)
Vrow96 row96 0 PULSE(0 0.0199263201594 0 0.001n 0.001n 10n 30n)
Vrow97 row97 0 PULSE(0 -0.0221245407429 0 0.001n 0.001n 10n 30n)
Vrow98 row98 0 PULSE(0 -0.0181816693093 0 0.001n 0.001n 10n 30n)
Vrow99 row99 0 PULSE(0 -0.0258140054675 0 0.001n 0.001n 10n 30n)
Vrow100 row100 0 PULSE(0 -0.0643415076835 0 0.001n 0.001n 10n 30n)
Vrow101 row101 0 PULSE(0 -0.00318430293727 0 0.001n 0.001n 10n 30n)
Vrow102 row102 0 PULSE(0 0.0027456582184 0 0.001n 0.001n 10n 30n)
Vrow103 row103 0 PULSE(0 0.0384495879147 0 0.001n 0.001n 10n 30n)
Vrow104 row104 0 PULSE(0 -0.0148968302053 0 0.001n 0.001n 10n 30n)
Vrow105 row105 0 PULSE(0 -0.0517677863066 0 0.001n 0.001n 10n 30n)
Vrow106 row106 0 PULSE(0 0.00461384878575 0 0.001n 0.001n 10n 30n)
Vrow107 row107 0 PULSE(0 0.0333066125617 0 0.001n 0.001n 10n 30n)
Vrow108 row108 0 PULSE(0 0.0756338388193 0 0.001n 0.001n 10n 30n)
Vrow109 row109 0 PULSE(0 0.00841843229757 0 0.001n 0.001n 10n 30n)
Vrow110 row110 0 PULSE(0 0.0028993749231 0 0.001n 0.001n 10n 30n)
Vrow111 row111 0 PULSE(0 0.0227255490205 0 0.001n 0.001n 10n 30n)
Vrow112 row112 0 PULSE(0 -0.0254890454098 0 0.001n 0.001n 10n 30n)
Vrow113 row113 0 PULSE(0 -0.00174454139623 0 0.001n 0.001n 10n 30n)
Vrow114 row114 0 PULSE(0 0.00101762681267 0 0.001n 0.001n 10n 30n)
Vrow115 row115 0 PULSE(0 -0.0122244892266 0 0.001n 0.001n 10n 30n)
Vrow116 row116 0 PULSE(0 -0.0109511382302 0 0.001n 0.001n 10n 30n)
Vrow117 row117 0 PULSE(0 0.0306189676897 0 0.001n 0.001n 10n 30n)
Vrow118 row118 0 PULSE(0 0.00452663441539 0 0.001n 0.001n 10n 30n)
Vrow119 row119 0 PULSE(0 -0.0357526563046 0 0.001n 0.001n 10n 30n)
Vrow120 row120 0 PULSE(0 0.0118053371156 0 0.001n 0.001n 10n 30n)
Vrow121 row121 0 PULSE(0 -0.00806889353609 0 0.001n 0.001n 10n 30n)
Vrow122 row122 0 PULSE(0 -0.0163668585421 0 0.001n 0.001n 10n 30n)
Vrow123 row123 0 PULSE(0 0.00950439970794 0 0.001n 0.001n 10n 30n)
Vrow124 row124 0 PULSE(0 -0.00908646421858 0 0.001n 0.001n 10n 30n)
Vrow125 row125 0 PULSE(0 0.0209091638018 0 0.001n 0.001n 10n 30n)
Vrow126 row126 0 PULSE(0 -0.048047612761 0 0.001n 0.001n 10n 30n)
Vrow127 row127 0 PULSE(0 -0.0167597094545 0 0.001n 0.001n 10n 30n)
Reqrow0 row0 0 58.5127606715
Reqrow1 row1 0 54.6316900224
Reqrow2 row2 0 50.0764201155
Reqrow3 row3 0 69.9196397352
Reqrow4 row4 0 54.461876813
Reqrow5 row5 0 56.0826431988
Reqrow6 row6 0 60.4931562271
Reqrow7 row7 0 61.7315039784
Reqrow8 row8 0 62.3561357739
Reqrow9 row9 0 59.8818507911
Reqrow10 row10 0 53.6624056244
Reqrow11 row11 0 55.0002484108
Reqrow12 row12 0 54.6572463461
Reqrow13 row13 0 62.3597461316
Reqrow14 row14 0 63.8289908705
Reqrow15 row15 0 57.3199050457
Reqrow16 row16 0 48.8489789772
Reqrow17 row17 0 65.6587227881
Reqrow18 row18 0 55.1274927991
Reqrow19 row19 0 67.8638657007
Reqrow20 row20 0 56.7242510569
Reqrow21 row21 0 50.0855701559
Reqrow22 row22 0 57.246191061
Reqrow23 row23 0 54.1778598646
Reqrow24 row24 0 63.6089748462
Reqrow25 row25 0 53.4599935444
Reqrow26 row26 0 66.18811642
Reqrow27 row27 0 53.1288398958
Reqrow28 row28 0 53.4632187759
Reqrow29 row29 0 62.8140539321
Reqrow30 row30 0 65.2717688406
Reqrow31 row31 0 59.2131115631
Reqrow32 row32 0 57.9341743689
Reqrow33 row33 0 55.070499093
Reqrow34 row34 0 62.2002660509
Reqrow35 row35 0 62.9940453162
Reqrow36 row36 0 57.8051108754
Reqrow37 row37 0 50.5695865098
Reqrow38 row38 0 50.9271800849
Reqrow39 row39 0 51.5869462296
Reqrow40 row40 0 68.1758865055
Reqrow41 row41 0 59.1655687503
Reqrow42 row42 0 48.8184945359
Reqrow43 row43 0 67.1535696048
Reqrow44 row44 0 62.1182026
Reqrow45 row45 0 51.4249965211
Reqrow46 row46 0 53.0923424021
Reqrow47 row47 0 62.0396487334
Reqrow48 row48 0 59.7013756596
Reqrow49 row49 0 59.6417233874
Reqrow50 row50 0 57.4894300622
Reqrow51 row51 0 57.9886628552
Reqrow52 row52 0 59.1936254406
Reqrow53 row53 0 54.4255257813
Reqrow54 row54 0 62.3081191233
Reqrow55 row55 0 59.5036481294
Reqrow56 row56 0 67.843022467
Reqrow57 row57 0 44.9457245192
Reqrow58 row58 0 52.1555597248
Reqrow59 row59 0 59.9641201242
Reqrow60 row60 0 50.3783770569
Reqrow61 row61 0 66.8844927327
Reqrow62 row62 0 79.4812365462
Reqrow63 row63 0 55.6320372936
Reqrow64 row64 0 58.5406212199
Reqrow65 row65 0 63.9602022894
Reqrow66 row66 0 55.3343602986
Reqrow67 row67 0 51.2374256532
Reqrow68 row68 0 57.9644453224
Reqrow69 row69 0 71.858290433
Reqrow70 row70 0 61.8806481869
Reqrow71 row71 0 64.0029556813
Reqrow72 row72 0 60.0963393051
Reqrow73 row73 0 65.6831020018
Reqrow74 row74 0 52.8370974783
Reqrow75 row75 0 51.7343902159
Reqrow76 row76 0 56.7313383761
Reqrow77 row77 0 65.6590502596
Reqrow78 row78 0 67.7422774096
Reqrow79 row79 0 66.0826745855
Reqrow80 row80 0 61.8747379052
Reqrow81 row81 0 49.8384160469
Reqrow82 row82 0 52.0431061528
Reqrow83 row83 0 59.6529712198
Reqrow84 row84 0 48.1734992552
Reqrow85 row85 0 62.4434022036
Reqrow86 row86 0 64.4569448391
Reqrow87 row87 0 56.7727442184
Reqrow88 row88 0 64.8596242591
Reqrow89 row89 0 51.2587003039
Reqrow90 row90 0 57.0431056976
Reqrow91 row91 0 74.4586143393
Reqrow92 row92 0 67.3182092419
Reqrow93 row93 0 60.5265175015
Reqrow94 row94 0 66.9177936771
Reqrow95 row95 0 53.1592699926
Reqrow96 row96 0 64.5958676984
Reqrow97 row97 0 57.9586273057
Reqrow98 row98 0 65.1992848314
Reqrow99 row99 0 59.7647754923
Reqrow100 row100 0 54.9217707951
Reqrow101 row101 0 45.2553551793
Reqrow102 row102 0 60.9070835988
Reqrow103 row103 0 53.667452063
Reqrow104 row104 0 52.0506017575
Reqrow105 row105 0 55.7768166626
Reqrow106 row106 0 67.5900537823
Reqrow107 row107 0 56.9726933211
Reqrow108 row108 0 61.7831177476
Reqrow109 row109 0 62.1329074213
Reqrow110 row110 0 57.8162668021
Reqrow111 row111 0 61.8712261949
Reqrow112 row112 0 64.6283716423
Reqrow113 row113 0 73.9015561456
Reqrow114 row114 0 62.7808376184
Reqrow115 row115 0 62.1502605623
Reqrow116 row116 0 50.9542568594
Reqrow117 row117 0 47.6801701023
Reqrow118 row118 0 52.8206381509
Reqrow119 row119 0 51.8942640961
Reqrow120 row120 0 50.0663224552
Reqrow121 row121 0 67.1734799687
Reqrow122 row122 0 55.8982619862
Reqrow123 row123 0 62.8392175974
Reqrow124 row124 0 52.1200960875
Reqrow125 row125 0 61.4219450995
Reqrow126 row126 0 73.4810440441
Reqrow127 row127 0 46.0284021412
Bpwr pwr 0 v = (v(row0)*v(row0)/58.5127606715) + (v(row1)*v(row1)/54.6316900224) + (v(row2)*v(row2)/50.0764201155) + (v(row3)*v(row3)/69.9196397352) + (v(row4)*v(row4)/54.461876813) + (v(row5)*v(row5)/56.0826431988) + (v(row6)*v(row6)/60.4931562271) + (v(row7)*v(row7)/61.7315039784) + (v(row8)*v(row8)/62.3561357739) + (v(row9)*v(row9)/59.8818507911) + (v(row10)*v(row10)/53.6624056244) + (v(row11)*v(row11)/55.0002484108) + (v(row12)*v(row12)/54.6572463461) + (v(row13)*v(row13)/62.3597461316) + (v(row14)*v(row14)/63.8289908705) + (v(row15)*v(row15)/57.3199050457) + (v(row16)*v(row16)/48.8489789772) + (v(row17)*v(row17)/65.6587227881) + (v(row18)*v(row18)/55.1274927991) + (v(row19)*v(row19)/67.8638657007) + (v(row20)*v(row20)/56.7242510569) + (v(row21)*v(row21)/50.0855701559) + (v(row22)*v(row22)/57.246191061) + (v(row23)*v(row23)/54.1778598646) + (v(row24)*v(row24)/63.6089748462) + (v(row25)*v(row25)/53.4599935444) + (v(row26)*v(row26)/66.18811642) + (v(row27)*v(row27)/53.1288398958) + (v(row28)*v(row28)/53.4632187759) + (v(row29)*v(row29)/62.8140539321) + (v(row30)*v(row30)/65.2717688406) + (v(row31)*v(row31)/59.2131115631) + (v(row32)*v(row32)/57.9341743689) + (v(row33)*v(row33)/55.070499093) + (v(row34)*v(row34)/62.2002660509) + (v(row35)*v(row35)/62.9940453162) + (v(row36)*v(row36)/57.8051108754) + (v(row37)*v(row37)/50.5695865098) + (v(row38)*v(row38)/50.9271800849) + (v(row39)*v(row39)/51.5869462296) + (v(row40)*v(row40)/68.1758865055) + (v(row41)*v(row41)/59.1655687503) + (v(row42)*v(row42)/48.8184945359) + (v(row43)*v(row43)/67.1535696048) + (v(row44)*v(row44)/62.1182026) + (v(row45)*v(row45)/51.4249965211) + (v(row46)*v(row46)/53.0923424021) + (v(row47)*v(row47)/62.0396487334) + (v(row48)*v(row48)/59.7013756596) + (v(row49)*v(row49)/59.6417233874) + (v(row50)*v(row50)/57.4894300622) + (v(row51)*v(row51)/57.9886628552) + (v(row52)*v(row52)/59.1936254406) + (v(row53)*v(row53)/54.4255257813) + (v(row54)*v(row54)/62.3081191233) + (v(row55)*v(row55)/59.5036481294) + (v(row56)*v(row56)/67.843022467) + (v(row57)*v(row57)/44.9457245192) + (v(row58)*v(row58)/52.1555597248) + (v(row59)*v(row59)/59.9641201242) + (v(row60)*v(row60)/50.3783770569) + (v(row61)*v(row61)/66.8844927327) + (v(row62)*v(row62)/79.4812365462) + (v(row63)*v(row63)/55.6320372936) + (v(row64)*v(row64)/58.5406212199) + (v(row65)*v(row65)/63.9602022894) + (v(row66)*v(row66)/55.3343602986) + (v(row67)*v(row67)/51.2374256532) + (v(row68)*v(row68)/57.9644453224) + (v(row69)*v(row69)/71.858290433) + (v(row70)*v(row70)/61.8806481869) + (v(row71)*v(row71)/64.0029556813) + (v(row72)*v(row72)/60.0963393051) + (v(row73)*v(row73)/65.6831020018) + (v(row74)*v(row74)/52.8370974783) + (v(row75)*v(row75)/51.7343902159) + (v(row76)*v(row76)/56.7313383761) + (v(row77)*v(row77)/65.6590502596) + (v(row78)*v(row78)/67.7422774096) + (v(row79)*v(row79)/66.0826745855) + (v(row80)*v(row80)/61.8747379052) + (v(row81)*v(row81)/49.8384160469) + (v(row82)*v(row82)/52.0431061528) + (v(row83)*v(row83)/59.6529712198) + (v(row84)*v(row84)/48.1734992552) + (v(row85)*v(row85)/62.4434022036) + (v(row86)*v(row86)/64.4569448391) + (v(row87)*v(row87)/56.7727442184) + (v(row88)*v(row88)/64.8596242591) + (v(row89)*v(row89)/51.2587003039) + (v(row90)*v(row90)/57.0431056976) + (v(row91)*v(row91)/74.4586143393) + (v(row92)*v(row92)/67.3182092419) + (v(row93)*v(row93)/60.5265175015) + (v(row94)*v(row94)/66.9177936771) + (v(row95)*v(row95)/53.1592699926) + (v(row96)*v(row96)/64.5958676984) + (v(row97)*v(row97)/57.9586273057) + (v(row98)*v(row98)/65.1992848314) + (v(row99)*v(row99)/59.7647754923) + (v(row100)*v(row100)/54.9217707951) + (v(row101)*v(row101)/45.2553551793) + (v(row102)*v(row102)/60.9070835988) + (v(row103)*v(row103)/53.667452063) + (v(row104)*v(row104)/52.0506017575) + (v(row105)*v(row105)/55.7768166626) + (v(row106)*v(row106)/67.5900537823) + (v(row107)*v(row107)/56.9726933211) + (v(row108)*v(row108)/61.7831177476) + (v(row109)*v(row109)/62.1329074213) + (v(row110)*v(row110)/57.8162668021) + (v(row111)*v(row111)/61.8712261949) + (v(row112)*v(row112)/64.6283716423) + (v(row113)*v(row113)/73.9015561456) + (v(row114)*v(row114)/62.7808376184) + (v(row115)*v(row115)/62.1502605623) + (v(row116)*v(row116)/50.9542568594) + (v(row117)*v(row117)/47.6801701023) + (v(row118)*v(row118)/52.8206381509) + (v(row119)*v(row119)/51.8942640961) + (v(row120)*v(row120)/50.0663224552) + (v(row121)*v(row121)/67.1734799687) + (v(row122)*v(row122)/55.8982619862) + (v(row123)*v(row123)/62.8392175974) + (v(row124)*v(row124)/52.1200960875) + (v(row125)*v(row125)/61.4219450995) + (v(row126)*v(row126)/73.4810440441) + (v(row127)*v(row127)/46.0284021412)
.control
set filetype=ascii
tran 0.05n 10.002n
meas tran energy INTEG v(pwr) FROM=0n TO=10.002n
wrdata experiments/spice/results/cmm_crosssim_read_energy/spice_validation/high_layers_1_cross_attn_v_proj_r0c0.dat v(pwr)
quit
.endc
.end
